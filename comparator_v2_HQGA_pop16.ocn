(procedure execute(w_m1 w_m67 w_m89 c01)
  analysis('tran ?stop "50n"  )

  desVar(   "W_M1" w_m1 )
  desVar(   "W_M6" w_m67 )
  desVar(   "W_M7" w_m67)
  desVar(   "W_M8" w_m89)
  desVar(   "W_M9" w_m89)
  desVar(   "C1" c01)
  desVar(   "C0" c01)

  envOption(
         'analysisOrder  list("dc" "tran")
  )

  ;save( 'v "/in+" "/in-" "/clk" "/out-" "/out+" )
  ;save( 'i "/Vdd/MINUS" )
  temp( 27 )

  run()

  selectResult( 'tran )
  ;plot(getData("/in+") getData("/in-") getData("/clk") getData("/out-") getData("/out+") )
  ;plot( IT("/Vdd/MINUS") )

  integral = integ(IT("/Vdd/MINUS") 0 1n )
  if((integral == nil) then Power = 0.0 else Power = 1e+9 * 1.2 * integral)

  Delay = delay( ?wf1 v("/clk" ?result "tran") ?value1 0.012 ?edge1 "rising" ?nth1 1 ?td1 0 ?wf2 abs((v("/out+" ?result "tran") - v("/out-" ?result "tran"))) ?value2 0.6 ?edge2 "either" ?nth2 1 ?td2 0 ?stop 4e-07 ?period1 1 ?period2 2 ?multiple t ?xName "trigger" )
  DelayAvg = average(Delay)

  ;fprintf( fout "%s, %s, %s, %s\n", w_m1, w_m67, w_m89, c01)
  fprintf( fout "%f\n", DelayAvg * 1e+12)
  fprintf( fout "%f\n", Power*1e+6 )

) ; close procedure

fout = outfile("HQGA_results.txt" "w")

fin = infile("HQGA_params.txt")
fscanf(fin "\n%s" w_m1_1)
fscanf(fin "\n%s" w_m1_2)
fscanf(fin "\n%s" w_m1_3)
fscanf(fin "\n%s" w_m1_4)
fscanf(fin "\n%s" w_m1_5)
fscanf(fin "\n%s" w_m1_6)
fscanf(fin "\n%s" w_m1_7)
fscanf(fin "\n%s" w_m1_8)
fscanf(fin "\n%s" w_m1_9)
fscanf(fin "\n%s" w_m1_10)
fscanf(fin "\n%s" w_m1_11)
fscanf(fin "\n%s" w_m1_12)
fscanf(fin "\n%s" w_m1_13)
fscanf(fin "\n%s" w_m1_14)
fscanf(fin "\n%s" w_m1_15)
fscanf(fin "\n%s" w_m1_16)

fscanf(fin "\n%s" w_m67_1)
fscanf(fin "\n%s" w_m67_2)
fscanf(fin "\n%s" w_m67_3)
fscanf(fin "\n%s" w_m67_4)
fscanf(fin "\n%s" w_m67_5)
fscanf(fin "\n%s" w_m67_6)
fscanf(fin "\n%s" w_m67_7)
fscanf(fin "\n%s" w_m67_8)
fscanf(fin "\n%s" w_m67_9)
fscanf(fin "\n%s" w_m67_10)
fscanf(fin "\n%s" w_m67_11)
fscanf(fin "\n%s" w_m67_12)
fscanf(fin "\n%s" w_m67_13)
fscanf(fin "\n%s" w_m67_14)
fscanf(fin "\n%s" w_m67_15)
fscanf(fin "\n%s" w_m67_16)

fscanf(fin "\n%s" w_m89_1)
fscanf(fin "\n%s" w_m89_2)
fscanf(fin "\n%s" w_m89_3)
fscanf(fin "\n%s" w_m89_4)
fscanf(fin "\n%s" w_m89_5)
fscanf(fin "\n%s" w_m89_6)
fscanf(fin "\n%s" w_m89_7)
fscanf(fin "\n%s" w_m89_8)
fscanf(fin "\n%s" w_m89_9)
fscanf(fin "\n%s" w_m89_10)
fscanf(fin "\n%s" w_m89_11)
fscanf(fin "\n%s" w_m89_12)
fscanf(fin "\n%s" w_m89_13)
fscanf(fin "\n%s" w_m89_14)
fscanf(fin "\n%s" w_m89_15)
fscanf(fin "\n%s" w_m89_16)

fscanf(fin "\n%s" c01_1)
fscanf(fin "\n%s" c01_2)
fscanf(fin "\n%s" c01_3)
fscanf(fin "\n%s" c01_4)
fscanf(fin "\n%s" c01_5)
fscanf(fin "\n%s" c01_6)
fscanf(fin "\n%s" c01_7)
fscanf(fin "\n%s" c01_8)
fscanf(fin "\n%s" c01_9)
fscanf(fin "\n%s" c01_10)
fscanf(fin "\n%s" c01_11)
fscanf(fin "\n%s" c01_12)
fscanf(fin "\n%s" c01_13)
fscanf(fin "\n%s" c01_14)
fscanf(fin "\n%s" c01_15)
fscanf(fin "\n%s" c01_16)

simulator( 'spectre )
design( "/home/disk/simulation/SIM_IC61/conventional_comparator/spectre/schematic/netlist/netlist" )
resultsDir( "/home/disk/simulation/SIM_IC61/conventional_comparator/spectre/schematic" )
modelFile(
    '("/home/hoangtrang/Thu_vien_PDK/PDK_CRN65LP_v1.7a_Official_IC61_20120914_all/PDK_CRN65LP_v1.7a_Official_IC61_20120914/tsmcN65/../models/spectre/toplevel.scs" "tt_lib")
)

execute(w_m1_1 w_m67_1 w_m89_1 c01_1)
execute(w_m1_2 w_m67_2 w_m89_2 c01_2)
execute(w_m1_3 w_m67_3 w_m89_3 c01_3)
execute(w_m1_4 w_m67_4 w_m89_4 c01_4)
execute(w_m1_5 w_m67_5 w_m89_5 c01_5)
execute(w_m1_5 w_m67_6 w_m89_6 c01_6)
execute(w_m1_7 w_m67_7 w_m89_7 c01_7)
execute(w_m1_8 w_m67_8 w_m89_8 c01_8)
execute(w_m1_9 w_m67_9 w_m89_9 c01_9)
execute(w_m1_10 w_m67_10 w_m89_10 c01_10)
execute(w_m1_11 w_m67_11 w_m89_11 c01_11)
execute(w_m1_12 w_m67_12 w_m89_12 c01_12)
execute(w_m1_13 w_m67_13 w_m89_13 c01_13)
execute(w_m1_14 w_m67_14 w_m89_14 c01_14)
execute(w_m1_15 w_m67_15 w_m89_15 c01_15)
execute(w_m1_16 w_m67_16 w_m89_16 c01_16)

close(fout)

exit
